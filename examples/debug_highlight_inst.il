load("/home/cloud/projects/skillbridge/examples/highlight_net.il")
SBhilightInsts(geGetEditCellView() "NM1")
